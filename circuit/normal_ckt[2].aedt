# Ansys Electronics Desktop project, version 2024.2

design Circuit1 (Circuit)
options: SParamCircuitDef IntegrationMethod=FFT
components:
  V2 = V_PULSE(V2=1V TR=50ps TF=50ps PW=100ps PER=100ps)
  S1 = GAIN_NX(GAIN=2 RO=50)
  T1 = TRLK_NX(P=20.7mm K=2.1 A=0.0966 TAND=0.02)
  S2 = GAIN_NX(GAIN=2 RO=50)
  T2 = TRLK_NX(P=20.7mm K=2.1 A=0.0966 TAND=0.02)
  S3 = GAIN_NX(GAIN=2 RO=50)
  T3 = TRLK_NX(P=20.7mm K=2.1 A=0.0966 TAND=0.02)
  S4 = GAIN_NX(GAIN=2 RO=50)
  T4 = TRLK_NX(P=20.7mm K=2.1 A=0.0966 TAND=0.02)
  T5 = TRLK_NX(P=20.7mm K=2.1 A=0.0966 TAND=0.02)
  S5 = GAIN_NX(GAIN=2 RO=50)
  R_X = RES_()
  Z77 = VPROBE(Name=OUTPUT)
  Z78 = VPROBE(Name=INPUT)
  A83 = EYESOURCE()
  A84 = EYEPROBE(source_name=AEYESOURCE83)
nets:
  0: V2.1, R_X.0
  net_10: S5.0, T4.1
  net_11: S5.1, Z77.0, R_X.1, A84.0
  net_12: V2.0, T5.0, Z78.0, A83.0
  net_2: S1.0, T5.1
  net_3: T1.0, S1.1
  net_4: T1.1, S2.0
  net_5: S2.1, T2.0
  net_6: S3.0, T2.1
  net_7: S3.1, T3.0
  net_8: S4.0, T3.1
  net_9: T4.0, S4.1
setups:
  NexximTransient: TransientData(1ps, 1ns) TransientNoiseData(false, "", "", 0, 1, 0, false, 1) TransientOtherData(default, false)
  NexximTransient1: TransientData(10ps, 200ns) TransientNoiseData(false, "", "", 0, 1, 0, false, 1) TransientOtherData(default, false)
reports:
  Transient Voltage Plot 1: V(INPUT) vs Time on NexximTransient : NexximTransient
  Transient Voltage Plot 2: V(OUTPUT) vs Time on NexximTransient : NexximTransient
  Transient Voltage Plot 3: EyeLevelZero(V(OUTPUT), 0ns, 0ns, 0ns, 1, 0mV) vs Time on NexximTransient : NexximTransient
  Transient Voltage Plot 4: EyeHeight(V(INPUT), 1ns, 0ns, 0ns, 1 , 0mV) vs Time on NexximTransient : NexximTransient
  Transient Voltage Plot 5: EyeHeight(V(OUTPUT), 1ns, 0ns, 0ns, 1, 0mV) vs Time on NexximTransient : NexximTransient
  Transient Voltage Plot 6: EyeHeight(V(OUTPUT), 1ns, 0ns, 0ns, 1, 0mV) vs Time on NexximTransient : NexximTransient
  Transient Voltage Plot 7: V(OUTPUT) vs Time on NexximTransient : NexximTransient
  Transient Voltage Plot 8: V(OUTPUT) vs Time on NexximTransient : NexximTransient
  Transient Voltage Plot 9: V(AEYEPROBE(required).out) vs Time on NexximTransient1 : NexximTransient1
  Transient Voltage Plot 10: V(INPUT) vs Time on NexximTransient1 : NexximTransient1
  Transient Voltage Plot 11: V(INPUT) vs Time on NexximTransient1 : NexximTransient1
